CB - DC ANALYSIS
*
Q1   1   0   2   Q2SC1815
VCC  1   0   50V
VEE  0   3   5V
I1   2   3   1mA
*
.MODEL Q2SC1815 NPN (IS=1.0E-14 BF=170 BR=3.6 VAF=100 IK=0.15
+ RB=50 TF=0.5N TR=20N CJE=18P CJC=4.8P XTB=1.7)
.DC VCC -1 50 0.01 I1 0 0.002 0.0004
.PROBE
.END
