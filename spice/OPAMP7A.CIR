OPAMP7A - MULTIPLE ANALYSES
*
Q1  1    IN   3   Q2SA872A
Q2  VEE   5   3   Q2SA872A
Q3  3     6   7   Q2SA1015
Q4  8     1  VEE  Q2SC1815
Q5  9    10  11   Q2SA1015
R2  7    VCC  1.5K
D1  VCC  13   D1S1588
D2  13    6   D1S1588
R1  VEE   6   10K
R3  VEE   1   3.9K
R4  10    6   470
C1  8     1   15P
R5  11   VCC  100
R6  OUT   5   10K
R7  0     5   1K
V1  IN    0   AC 1V SIN(0 1 1K)
V2  VCC   0   15V
V3  0    VEE  15V
RL  0    OUT  1K
D3  9    15   D1S1588
D4  15   16   D1S1588
D5  16    8   D1S1588
Q6  VCC   9   17   Q2SC1815
Q7  VEE   8   18   Q2SA1015
R8  OUT  17   47
R9  18   OUT  47
*
.MODEL D1S1588 D (IS=4.4E-14 RS=3.8)
.MODEL Q2SA872A PNP (IS=1.5E-14 BF=500 VAF=150
+ RB=200 TF=1.3N CJE=5P CJC=6.6P)
.MODEL Q2SA1015 PNP (IS=1.4E-14 BF=170 VAF=100
+ RB=30 TF=0.63N CJE=12P CJC=11P)
.MODEL Q2SC1815 NPN (IS=1.0E-14 BF=170 VAF=100
+ RB=50 TF=0.5N CJE=18P CJC=4.8P)
*
.TRAN 3.92927e-006 0.002 0 1e-005
.AC DEC 63 1 1e+008
.PROBE
* #destroy all
* #run
* #plot tran1.v(in) tran1.v(out)
* #plot ab(ac1.v(out)/(ac1.v(in)-ac1.v(5)))
* #plot ph(ac1.v(out)/(ac1.v(in)-ac1.v(5))) * 180/pi
.END
