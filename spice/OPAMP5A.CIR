MULTIPLE ANALYSES
*
Q1  1    2    3   Q2SA872A
Q2  4    5    3   Q2SA872A
Q3  3    6    7   Q2SA1015
Q4  OUT  1    4   Q2SC1815
Q5  OUT  9   10   Q2SA1015
R2  7   11   1.5K
D1  11  12   D1S1588
D2  12   6   D1S1588
R1  4    6   10K
R3  4    1   3.9K
R4  9    6   470
C1  1   OUT  15P
R5  10  11   100
R6  OUT  5   10K
R7  0    5   1K
V1  2    0   AC 1V SIN(0 1 1000)
V2  11   0   15V
V3  0    4   15V
RL  0   OUT  1K
*
.MODEL D1S1588 D (IS=4.4E-14 RS=3.8)
.MODEL Q2SC1815 NPN (IS=1.0E-14 BF=170 VAF=100
+ RB=50 TF=0.5N CJE=18P CJC=4.8P)
.MODEL Q2SA872A PNP (IS=1.5E-14 BF=500 VAF=150
+ RB=200 TF=1.3N CJE=5P CJC=6.6P)
.MODEL Q2SA1015 PNP (IS=1.4E-14 BF=170 VAF=100
+ RB=30 TF=0.63N CJE=12P CJC=11P)
.TRAN 3.92927e-006 0.002 0 1e-005
.AC DEC 63 1 1e+008
.PROBE
* #destroy all
* #run
* #plot tran1.v(out) tran1.v(2)
* #plot ab(ac1.v(out)/(ac1.v(2)-ac1.v(5)))
* #plot ph(ac1.v(out)/(ac1.v(2)-ac1.v(5))) * 180/pi
.END
