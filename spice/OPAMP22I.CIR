OPAMP22I - MULTIPLE ANALYSES
*
J1   1    2    3   JUPA63H
J2   4    5    3   JUPA63H
Q1   6    7    1   Q2SC1775A
Q2   8    7    4   Q2SC1775A
R2   2   IN        470
C1   0    2        10P
Q7  10   11    6   Q2SA1145
Q8   6   12   11   Q2SC1815
Q9   8   12   13   Q2SC1815
Q10 14   13    8   Q2SA1145
Q11 15   15   16   Q2SC1815
Q12 17   15   18   Q2SC1815
R12 15   10        10K
R13 15   11        100K
R17 19   13        100K
R18 VEE  16        330
R19 VEE  18        330
Q13 17   15   19   Q2SA1015
Q14 14   19   17   Q2SC2705
R21 21   14        47
C4   0   14        10P
Q15 26   21   27   Q2SA1015
Q16 22   21   23   Q2SC1815
Q19 VCC  25   22   Q2SC2911
Q20 VEE  29   26   Q2SA1209
D6  25   27        D1S1588
D7  23   29        D1S1588
D8  22   25        D1S1588
D9  29   26        D1S1588
R24 28   22        33
R25 26   28        33
R30 28   30        100
R31 30    5        5K
R32  0    5        560
R33 OUT  28        100
R34  0   OUT        1G
C3  15   10        5P
C5  29   25        0.01U
C6  30    5        1P
V1  IN    0   AC 1V PULSE(-0.1 0.1 1U 1N 1N 1U 2U)
V2  VCC   0   50V
V3   0   VEE  50V
V5   7    3   4V
V7  VCC  12   6V
I1   3   VEE  4.3mA
I2  VCC  25   2mA
I3  29   VEE  2mA
I4  VCC   6   8mA
I5  VCC   8   8mA
*
.MODEL D1S1588 D (IS=4.4E-14 RS=3.8)
.MODEL DLED D (IS=1E-30)
.MODEL Q2SA872A PNP (IS=1.5E-14 BF=500 VAF=150 RB=200 IK=0.025
+ TF=1.3N TR=52N CJE=5P CJC=6.6P XTB=1.4)
.MODEL Q2SA1015 PNP (IS=1.4E-14 BF=170 BR=10 VAF=100 IK=0.1
+ RB=30 TF=0.63N TR=25N CJE=12P CJC=11P XTB=1.3)
.MODEL Q2SC1815 NPN (IS=1.0E-14 BF=170 BR=3.6 VAF=100 IK=0.15
+ RB=50 TF=0.5N TR=20N CJE=18P CJC=4.8P XTB=1.7)
.MODEL Q2SC1775A NPN (IS=2.8E-14 BF=500 VAF=150V RB=200 IK=0.03
+ TF=0.5N TR=20N CJE=6.0P CJC=4.2P XTB=1.7)
.MODEL Q2SA1145 PNP (IS=2.1E-14 BF=160 VAF=200 RB=70 IK=0.05
+ TF=0.7N TR=28N CJE=20P CJC=7.5P XTB=1.7)
.MODEL Q2SC2705 NPN (IS=2.8E-14 BF=160 VAF=200 RB=70 IK=0.05
+ TF=0.7N TR=28N CJE=22P CJC=5.1P XTB=1.7)
.MODEL Q2SD756 NPN (IS=2.8E-14 BF=500 VAF=150V RB=200 IK=0.03
+ TF=0.5N TR=20N CJE=6.0P CJC=4.2P XTB=1.7)
.MODEL Q2SB716 PNP (IS=1.5E-14 BF=500 VAF=150V RB=200 IK=0.025
+ TF=1.3N TR=52N CJE=5P CJC=6.6P XTB=1.4)
.MODEL Q2SA1209 PNP (IS=4.0E-14 BF=250 VAF=100V RB=100 IK=0.07
+ TF=1N TR=40N CJE=50P CJC=12P XTB=1.3)
.MODEL Q2SC2911 NPN (IS=4.0E-14 BF=250 VAF=250V RB=100 IK=0.07
+ TF=0.8N TR=32N CJC=9P CJE=50P XTB=1.7)
.MODEL JUPA63H NJF (BETA=4M VTO=-1.2 CGS=6P CGD=4.5P)
.TRAN 9.80392e-009 5e-006 0 2e-009
.AC DEC 63 1 1e+008
.PROBE
.END
